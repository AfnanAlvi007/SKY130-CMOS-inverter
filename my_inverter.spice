* SPICE3 file created from my_inverter.ext - technology: scmos

.option scale=1u

M1000 out in gnd Gnd nfet w=4 l=2
+  ad=28p pd=22u as=28p ps=22u
M1001 out in vdd vdd pfet w=8 l=2
+  ad=56p pd=30u as=56p ps=30u
C0 out 0 2.632f **FLOATING
C1 in 0 6.344f **FLOATING
